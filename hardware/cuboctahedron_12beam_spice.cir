* ============================================================================
* cuboctahedron_12beam_spice.cir
* Full 3D 13-Node Cuboctahedron (1 Center + 12 Vertices, 12 Radial Spokes +
* 24 Surface Edges across 6 Square and 8 Triangular Faces) LC/RF Resonator
* simulated in Analog Devices LTspice.
* ============================================================================

.param f0 = 10Meg
.param L_spoke = 2.533u
.param L_surf  = 2.533u
.param C_node  = 100p
.param R_src   = 50
.param R_load  = 5000

* ============================================================================
* PART 1: COHERENT 12-BEAM CUBOCTAHEDRON RESONATOR (ALL 12 BEAMS IN PHASE)
* vs SINGLE-BEAM REFERENCE
* ============================================================================
* Central Node N0_COH
C0_COH N0_COH 0 {C_node}
R0_COH N0_COH 0 {R_load}

* 12 Cuboctahedron Vertex Sources & Radial Spokes to Center N0_COH:
* Plane XY (4 vertices: N1..N4)
V1_C  S1_C  0 SIN(0 1 {f0} 0 0 0)
V2_C  S2_C  0 SIN(0 1 {f0} 0 0 0)
V3_C  S3_C  0 SIN(0 1 {f0} 0 0 0)
V4_C  S4_C  0 SIN(0 1 {f0} 0 0 0)
* Plane XZ (4 vertices: N5..N8)
V5_C  S5_C  0 SIN(0 1 {f0} 0 0 0)
V6_C  S6_C  0 SIN(0 1 {f0} 0 0 0)
V7_C  S7_C  0 SIN(0 1 {f0} 0 0 0)
V8_C  S8_C  0 SIN(0 1 {f0} 0 0 0)
* Plane YZ (4 vertices: N9..N12)
V9_C  S9_C  0 SIN(0 1 {f0} 0 0 0)
V10_C S10_C 0 SIN(0 1 {f0} 0 0 0)
V11_C S11_C 0 SIN(0 1 {f0} 0 0 0)
V12_C S12_C 0 SIN(0 1 {f0} 0 0 0)

R1_C  S1_C  V1_N  {R_src}
R2_C  S2_C  V2_N  {R_src}
R3_C  S3_C  V3_N  {R_src}
R4_C  S4_C  V4_N  {R_src}
R5_C  S5_C  V5_N  {R_src}
R6_C  S6_C  V6_N  {R_src}
R7_C  S7_C  V7_N  {R_src}
R8_C  S8_C  V8_N  {R_src}
R9_C  S9_C  V9_N  {R_src}
R10_C S10_C V10_N {R_src}
R11_C S11_C V11_N {R_src}
R12_C S12_C V12_N {R_src}

* 12 Radial Spokes from the 12 Cuboctahedron Vertices to Central Node N0_COH
Lsp1_C  V1_N  N0_COH {L_spoke}
Lsp2_C  V2_N  N0_COH {L_spoke}
Lsp3_C  V3_N  N0_COH {L_spoke}
Lsp4_C  V4_N  N0_COH {L_spoke}
Lsp5_C  V5_N  N0_COH {L_spoke}
Lsp6_C  V6_N  N0_COH {L_spoke}
Lsp7_C  V7_N  N0_COH {L_spoke}
Lsp8_C  V8_N  N0_COH {L_spoke}
Lsp9_C  V9_N  N0_COH {L_spoke}
Lsp10_C V10_N N0_COH {L_spoke}
Lsp11_C V11_N N0_COH {L_spoke}
Lsp12_C V12_N N0_COH {L_spoke}

* 24 Surface Edges of the Cuboctahedron (connecting the 8 triangular faces
* across the XY, XZ, YZ Euler planes):
* Octant 1 (+X,+Y,+Z): triangle (V1_N in XY, V5_N in XZ, V9_N in YZ)
Le1_C  V1_N  V5_N  {L_surf}
Le2_C  V5_N  V9_N  {L_surf}
Le3_C  V9_N  V1_N  {L_surf}
* Octant 2 (+X,-Y,+Z): triangle (V2_N in XY, V5_N in XZ, V11_N in YZ)
Le4_C  V2_N  V5_N  {L_surf}
Le5_C  V5_N  V11_N {L_surf}
Le6_C  V11_N V2_N  {L_surf}
* Octant 3 (-X,-Y,+Z): triangle (V3_N in XY, V8_N in XZ, V11_N in YZ)
Le7_C  V3_N  V8_N  {L_surf}
Le8_C  V8_N  V11_N {L_surf}
Le9_C  V11_N V3_N  {L_surf}
* Octant 4 (-X,+Y,+Z): triangle (V4_N in XY, V8_N in XZ, V9_N in YZ)
Le10_C V4_N  V8_N  {L_surf}
Le11_C V8_N  V9_N  {L_surf}
Le12_C V9_N  V4_N  {L_surf}
* Octant 5 (+X,+Y,-Z): triangle (V1_N in XY, V6_N in XZ, V10_N in YZ)
Le13_C V1_N  V6_N  {L_surf}
Le14_C V6_N  V10_N {L_surf}
Le15_C V10_N V1_N  {L_surf}
* Octant 6 (+X,-Y,-Z): triangle (V2_N in XY, V6_N in XZ, V12_N in YZ)
Le16_C V2_N  V6_N  {L_surf}
Le17_C V6_N  V12_N {L_surf}
Le18_C V12_N V2_N  {L_surf}
* Octant 7 (-X,-Y,-Z): triangle (V3_N in XY, V7_N in XZ, V12_N in YZ)
Le19_C V3_N  V7_N  {L_surf}
Le20_C V7_N  V12_N {L_surf}
Le21_C V12_N V3_N  {L_surf}
* Octant 8 (-X,+Y,-Z): triangle (V4_N in XY, V7_N in XZ, V10_N in YZ)
Le22_C V4_N  V7_N  {L_surf}
Le23_C V7_N  V10_N {L_surf}
Le24_C V10_N V4_N  {L_surf}

* Single-Beam Reference Node N0_SINGLE (only 1 beam active, 11 passive)
C0_S N0_SINGLE 0 {C_node}
R0_S N0_SINGLE 0 {R_load}
V1_S S1_S 0 SIN(0 1 {f0} 0 0 0)
R1_S S1_S V1_SN {R_src}
Lsp1_S V1_SN N0_SINGLE {L_spoke}
* Other 11 spokes terminated passively to 50 Ohm
R2_S  0 V2_SN  {R_src}
R3_S  0 V3_SN  {R_src}
R4_S  0 V4_SN  {R_src}
R5_S  0 V5_SN  {R_src}
R6_S  0 V6_SN  {R_src}
R7_S  0 V7_SN  {R_src}
R8_S  0 V8_SN  {R_src}
R9_S  0 V9_SN  {R_src}
R10_S 0 V10_SN {R_src}
R11_S 0 V11_SN {R_src}
R12_S 0 V12_SN {R_src}
Lsp2_S  V2_SN  N0_SINGLE {L_spoke}
Lsp3_S  V3_SN  N0_SINGLE {L_spoke}
Lsp4_S  V4_SN  N0_SINGLE {L_spoke}
Lsp5_S  V5_SN  N0_SINGLE {L_spoke}
Lsp6_S  V6_SN  N0_SINGLE {L_spoke}
Lsp7_S  V7_SN  N0_SINGLE {L_spoke}
Lsp8_S  V8_SN  N0_SINGLE {L_spoke}
Lsp9_S  V9_SN  N0_SINGLE {L_spoke}
Lsp10_S V10_SN N0_SINGLE {L_spoke}
Lsp11_S V11_SN N0_SINGLE {L_spoke}
Lsp12_S V12_SN N0_SINGLE {L_spoke}

* ============================================================================
* PART 2: PAULI SINGLET VORTEX LOCK (6 BEAMS AT 0 DEG, 6 BEAMS AT 180 DEG)
* Central node net current cancels to 0 while surface plaquette vortex current
* circulates around the cuboctahedron edges!
* ============================================================================
C0_V N0_VORTEX 0 {C_node}
R0_V N0_VORTEX 0 {R_load}

V1_V  S1_V  0 SIN(0 1 {f0} 0 0 0)
V2_V  S2_V  0 SIN(0 1 {f0} 0 0 180)
V3_V  S3_V  0 SIN(0 1 {f0} 0 0 0)
V4_V  S4_V  0 SIN(0 1 {f0} 0 0 180)
V5_V  S5_V  0 SIN(0 1 {f0} 0 0 0)
V6_V  S6_V  0 SIN(0 1 {f0} 0 0 180)
V7_V  S7_V  0 SIN(0 1 {f0} 0 0 0)
V8_V  S8_V  0 SIN(0 1 {f0} 0 0 180)
V9_V  S9_V  0 SIN(0 1 {f0} 0 0 0)
V10_V S10_V 0 SIN(0 1 {f0} 0 0 180)
V11_V S11_V 0 SIN(0 1 {f0} 0 0 0)
V12_V S12_V 0 SIN(0 1 {f0} 0 0 180)

R1_V  S1_V  V1_VN  {R_src}
R2_V  S2_V  V2_VN  {R_src}
R3_V  S3_V  V3_VN  {R_src}
R4_V  S4_V  V4_VN  {R_src}
R5_V  S5_V  V5_VN  {R_src}
R6_V  S6_V  V6_VN  {R_src}
R7_V  S7_V  V7_VN  {R_src}
R8_V  S8_V  V8_VN  {R_src}
R9_V  S9_V  V9_VN  {R_src}
R10_V S10_V V10_VN {R_src}
R11_V S11_V V11_VN {R_src}
R12_V S12_V V12_VN {R_src}

Lsp1_V  V1_VN  N0_VORTEX {L_spoke}
Lsp2_V  V2_VN  N0_VORTEX {L_spoke}
Lsp3_V  V3_VN  N0_VORTEX {L_spoke}
Lsp4_V  V4_VN  N0_VORTEX {L_spoke}
Lsp5_V  V5_VN  N0_VORTEX {L_spoke}
Lsp6_V  V6_VN  N0_VORTEX {L_spoke}
Lsp7_V  V7_VN  N0_VORTEX {L_spoke}
Lsp8_V  V8_VN  N0_VORTEX {L_spoke}
Lsp9_V  V9_VN  N0_VORTEX {L_spoke}
Lsp10_V V10_VN N0_VORTEX {L_spoke}
Lsp11_V V11_VN N0_VORTEX {L_spoke}
Lsp12_V V12_VN N0_VORTEX {L_spoke}

* Surface edges on the vortex cuboctahedron carrying the circulating current
Le1_V  V1_VN  V2_VN  {L_surf}
Le2_V  V2_VN  V3_VN  {L_surf}
Le3_V  V3_VN  V4_VN  {L_surf}
Le4_V  V4_VN  V1_VN  {L_surf}

* ============================================================================
* PART 3: EULER-ANGLE TILT TRANSFER ACROSS THE 8 TRIANGULAR FACES (XY -> XZ, YZ)
* Only the 4 vertices of the horizontal XY plane are driven in quadrature
* (0 deg, 90 deg, 180 deg, 270 deg). The 8 vertices of the tilted XZ and YZ
* Euler planes have NO active generators and receive rotating wave energy
* purely through the 24 surface edges of the 8 triangular faces!
* ============================================================================
C0_E N0_EULER 0 {C_node}
R0_E N0_EULER 0 {R_load}

* Driven XY equatorial square (quadrature rotator: 0, 90, 180, 270 deg)
V1_E S1_E 0 SIN(0 1 {f0} 0 0 0)
V2_E S2_E 0 SIN(0 1 {f0} 0 0 90)
V3_E S3_E 0 SIN(0 1 {f0} 0 0 180)
V4_E S4_E 0 SIN(0 1 {f0} 0 0 270)
R1_E S1_E V1_EN {R_src}
R2_E S2_E V2_EN {R_src}
R3_E S3_E V3_EN {R_src}
R4_E S4_E V4_EN {R_src}

* Passive tilted XZ and YZ Euler squares (loaded by 500 Ohm detectors)
R5_E  0 V5_EN  500
R6_E  0 V6_EN  500
R7_E  0 V7_EN  500
R8_E  0 V8_EN  500
R9_E  0 V9_EN  500
R10_E 0 V10_EN 500
R11_E 0 V11_EN 500
R12_E 0 V12_EN 500

* 24 Surface Edges of the 8 Triangular Faces coupling XY -> XZ and YZ
Le1_E  V1_EN  V5_EN  {L_surf}
Le2_E  V5_EN  V9_EN  {L_surf}
Le3_E  V9_EN  V1_EN  {L_surf}
Le4_E  V2_EN  V5_EN  {L_surf}
Le5_E  V5_EN  V11_EN {L_surf}
Le6_E  V11_EN V2_EN  {L_surf}
Le7_E  V3_EN  V8_EN  {L_surf}
Le8_E  V8_EN  V11_EN {L_surf}
Le9_E  V11_EN V3_EN  {L_surf}
Le10_E V4_EN  V8_EN  {L_surf}
Le11_E V8_EN  V9_EN  {L_surf}
Le12_E V9_EN  V4_EN  {L_surf}
Le13_E V1_EN  V6_EN  {L_surf}
Le14_E V6_EN  V10_EN {L_surf}
Le15_E V10_EN V1_EN  {L_surf}
Le16_E V2_EN  V6_EN  {L_surf}
Le17_E V6_EN  V12_EN {L_surf}
Le18_E V12_EN V2_EN  {L_surf}
Le19_E V3_EN  V7_EN  {L_surf}
Le20_E V7_EN  V12_EN {L_surf}
Le21_E V12_EN V3_EN  {L_surf}
Le22_E V4_EN  V7_EN  {L_surf}
Le23_E V7_EN  V10_EN {L_surf}
Le24_E V10_EN V4_EN  {L_surf}

* ============================================================================
* PART 4: TWO-CHAMBER 12-BEAM CUBOCTAHEDRON BALLISTIC TELEPORTATION LINK
* Chamber A (12-beam transmitter resonator) -> Matched Ballistic LC Waveguide
* -> Chamber B (12-beam receiver resonator focus N0_TP_B)
* ============================================================================
V1_TPA  S1_TPA  0 SIN(0 1 {f0} 0 0 0)
V2_TPA  S2_TPA  0 SIN(0 1 {f0} 0 0 0)
V3_TPA  S3_TPA  0 SIN(0 1 {f0} 0 0 0)
V4_TPA  S4_TPA  0 SIN(0 1 {f0} 0 0 0)
V5_TPA  S5_TPA  0 SIN(0 1 {f0} 0 0 0)
V6_TPA  S6_TPA  0 SIN(0 1 {f0} 0 0 0)
V7_TPA  S7_TPA  0 SIN(0 1 {f0} 0 0 0)
V8_TPA  S8_TPA  0 SIN(0 1 {f0} 0 0 0)
V9_TPA  S9_TPA  0 SIN(0 1 {f0} 0 0 0)
V10_TPA S10_TPA 0 SIN(0 1 {f0} 0 0 0)
V11_TPA S11_TPA 0 SIN(0 1 {f0} 0 0 0)
V12_TPA S12_TPA 0 SIN(0 1 {f0} 0 0 0)

R1_TPA  S1_TPA  V1_TPAN  {R_src}
R2_TPA  S2_TPA  V2_TPAN  {R_src}
R3_TPA  S3_TPA  V3_TPAN  {R_src}
R4_TPA  S4_TPA  V4_TPAN  {R_src}
R5_TPA  S5_TPA  V5_TPAN  {R_src}
R6_TPA  S6_TPA  V6_TPAN  {R_src}
R7_TPA  S7_TPA  V7_TPAN  {R_src}
R8_TPA  S8_TPA  V8_TPAN  {R_src}
R9_TPA  S9_TPA  V9_TPAN  {R_src}
R10_TPA S10_TPA V10_TPAN {R_src}
R11_TPA S11_TPA V11_TPAN {R_src}
R12_TPA S12_TPA V12_TPAN {R_src}

Lsp1_TPA  V1_TPAN  N0_TP_A {L_spoke}
Lsp2_TPA  V2_TPAN  N0_TP_A {L_spoke}
Lsp3_TPA  V3_TPAN  N0_TP_A {L_spoke}
Lsp4_TPA  V4_TPAN  N0_TP_A {L_spoke}
Lsp5_TPA  V5_TPAN  N0_TP_A {L_spoke}
Lsp6_TPA  V6_TPAN  N0_TP_A {L_spoke}
Lsp7_TPA  V7_TPAN  N0_TP_A {L_spoke}
Lsp8_TPA  V8_TPAN  N0_TP_A {L_spoke}
Lsp9_TPA  V9_TPAN  N0_TP_A {L_spoke}
Lsp10_TPA V10_TPAN N0_TP_A {L_spoke}
Lsp11_TPA V11_TPAN N0_TP_A {L_spoke}
Lsp12_TPA V12_TPAN N0_TP_A {L_spoke}
C0_TPA N0_TP_A 0 {C_node}

* Shielded Ballistic Waveguide connecting Chamber A center (N0_TP_A) to Chamber B center (N0_TP_B)
L_WG1 N0_TP_A N_WG_MID {L_spoke}
C_WG1 N_WG_MID 0 {C_node}
L_WG2 N_WG_MID N0_TP_B {L_spoke}

* Chamber B 12-beam receiving focus (N0_TP_B) and 12 radial spokes
C0_TPB N0_TP_B 0 {C_node}
R0_TPB N0_TP_B 0 {R_load}
Lsp1_TPB  N0_TP_B V1_TPBN  {L_spoke}
Lsp2_TPB  N0_TP_B V2_TPBN  {L_spoke}
Lsp3_TPB  N0_TP_B V3_TPBN  {L_spoke}
Lsp4_TPB  N0_TP_B V4_TPBN  {L_spoke}
Lsp5_TPB  N0_TP_B V5_TPBN  {L_spoke}
Lsp6_TPB  N0_TP_B V6_TPBN  {L_spoke}
Lsp7_TPB  N0_TP_B V7_TPBN  {L_spoke}
Lsp8_TPB  N0_TP_B V8_TPBN  {L_spoke}
Lsp9_TPB  N0_TP_B V9_TPBN  {L_spoke}
Lsp10_TPB N0_TP_B V10_TPBN {L_spoke}
Lsp11_TPB N0_TP_B V11_TPBN {L_spoke}
Lsp12_TPB N0_TP_B V12_TPBN {L_spoke}
R1_TPB  V1_TPBN  0 500
R2_TPB  V2_TPBN  0 500
R3_TPB  V3_TPBN  0 500
R4_TPB  V4_TPBN  0 500
R5_TPB  V5_TPBN  0 500
R6_TPB  V6_TPBN  0 500
R7_TPB  V7_TPBN  0 500
R8_TPB  V8_TPBN  0 500
R9_TPB  V9_TPBN  0 500
R10_TPB V10_TPBN 0 500
R11_TPB V11_TPBN 0 500
R12_TPB V12_TPBN 0 500

* ============================================================================
* PART 5: PHYSICAL PERIPHERAL TRANSDUCER MODELS ON THE CUBOCTBUS-16 INTERFACE
*   (A) 12-Beam Ultrasonic Piezo Chamber (Butterworth-Van Dyke BVD equivalent
*       motional branch Lm_p, Cm_p, Rm_p + acoustic cavity standing-wave node)
*   (B) 12-Branch Asymmetric Diode Ratchet Rectifier Bridge (CE-RD-02 thermal
*       phase harvester charging the storage capacitor C_batt)
* ============================================================================
* (A) 12-Beam Ultrasonic Piezo Vat Model (driven in-phase by 12 beams -> acoustic pressure node P_ACOUSTIC)
.param C_p0 = 1000p
.param L_pm = 25.33u
.param C_pm = 10p
.param R_pm = 25
.param R_fluid = 1000

V_US_DRV S_US 0 SIN(0 5 {f0} 0 0 0)
* Equivalent parallel combination of 12 matched BVD piezo transducers converging on fluid cavity node N_ACOUSTIC_VAT:
R_US_SRC S_US N_PIEZO_IN 4.167
C_US_0   N_PIEZO_IN 0 {12*C_p0}
L_US_M   N_PIEZO_IN N_US_MID {L_pm/12}
C_US_M   N_US_MID   N_ACOUSTIC_VAT {12*C_pm}
R_US_M   N_US_MID   N_ACOUSTIC_VAT {R_pm/12}
R_VAT_LD N_ACOUSTIC_VAT 0 {R_fluid}
C_VAT_LD N_ACOUSTIC_VAT 0 {C_node}

* (B) Asymmetric Ratchet Harvester Peripheral (rectifying AC phase oscillations into DC vortex battery voltage V_RATCHET_DC)
V_RAT_SRC N_RAT_AC 0 SIN(0 2.18 {f0} 0 0 0)
R_RAT_SRC N_RAT_AC N_RAT_IN 50
D_RAT_POS N_RAT_IN N_RATCHET_DC D_SCHOTTKY
D_RAT_CLM 0        N_RAT_IN     D_SCHOTTKY
C_RAT_BAT N_RATCHET_DC 0 10n
R_RAT_BAT N_RATCHET_DC 0 100k
.model D_SCHOTTKY D(Is=1u Rs=2 N=1.05 Cjo=2p)

.tran 0 2u 1u 1n

.meas TRAN V_coh_pp    PP V(N0_COH)
.meas TRAN V_single_pp PP V(N0_SINGLE)
.meas TRAN Gain_amp    PARAM V_coh_pp/V_single_pp
.meas TRAN Gain_power  PARAM (V_coh_pp/V_single_pp)*(V_coh_pp/V_single_pp)
.meas TRAN V_vortex_center_pp PP V(N0_VORTEX)
.meas TRAN I_vortex_loop_pp   PP I(Le1_V)
.meas TRAN V_euler_xy_drive_pp PP V(V1_EN)
.meas TRAN V_euler_xz_tilt_pp  PP V(V5_EN)
.meas TRAN V_tp_chamberA_pp    PP V(N0_TP_A)
.meas TRAN V_tp_chamberB_pp    PP V(N0_TP_B)
.meas TRAN V_tp_spokeB_pp      PP V(V1_TPBN)
.meas TRAN V_acoustic_vat_pp   PP V(N_ACOUSTIC_VAT)
.meas TRAN V_ratchet_dc_avg    AVG V(N_RATCHET_DC)
.meas TRAN V_euler_yz_tilt_pp  PP V(V9_EN)

.end
