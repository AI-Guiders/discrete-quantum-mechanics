* ============================================================================
* hardware/kitchen_bench_mosfet_coil.cir
* Complete 12-Channel SPICE Circuit Model of the Cuboctahedron O_2(3) Kitchen Bench:
*   1. Tang Nano 9K LVCMOS33 GPIO Pins (12 channels CH00..CH11, 3.3 V,
*      f_512 = 27 MHz / 512 = 52,734.375 Hz, T_ring = 18.96296 us, 1 tick = 37.037 ns)
*   2. 12x MOSFET Gate Driver & Miller Plateau Networks (R_gate = 544 Ohm,
*      C_iss = 1.7 nF -> tau_gate = 925.9 ns = 25 ticks = d_out(E)^2)
*   3. 24 V Power Rail, PolySwitch PTC 10A/18A Fuse & 470 uF + 12x100nF X7R Decoupling
*   4. 12x Hand-Wound Air-Core Copper Field Coils (Z(Cu) = 29, N = 60 turns, MMF = 42 At,
*      L_eff = 100 uH, R_coil(25C) = 33.1 Ohm -> lag = 64 ticks = K_P)
*      + 12x Schottky Flyback Diodes (1N5819, tau_{L/R} = 3.02 us = 81 ticks, 3*81+13 = 256)
*      + O_2(3) Mutual Inductance Off-Axis Cancellation (4*(+1) + 2*0 + 4*(-1) == 0!)
*   5. Quartz Glass Petri Dish Wall (SiO2, Z = 30, 12 x 45 pF = 540 pF = 6 * 90 pF)
*      & Interior Air/Electrolyte Cavity Load (Z(N2+O2) = 30, R_cavity = 1536 Ohm)
* ============================================================================

.param F_CLK = 27Meg
.param N_RING = 512
.param F_RING = {F_CLK / N_RING}
.param T_RING = {1 / F_RING}
.param T_TICK = {1 / F_CLK}
.param TEMP_C = 25
.param ALPHA_CU = 0.00393
.param L_COIL = 100u
.param R_COIL_25 = 33.1
.param R_COIL_HOT = {R_COIL_25 * (1 + ALPHA_CU * (TEMP_C - 25))}

* 1. 24 V DC Laboratory Power Supply with PolySwitch PTC Fuse (R_ptc = 0.015 Ohm) & 470 uF Bulk Buffer:
V_PSU24 vin24 0 DC 24.0
R_PTC10 vin24 vdd24 0.015
C_DEC   vdd24 0 470u

* 2. Reusable Subcircuit for Each of the 12 Cuboctahedron O_2(3) Power Channels:
.subckt CUBOCT_COIL_CHANNEL fpga_pin drain dish_center vdd24
R_GATE fpga_pin gate 544
C_ISS  gate     0    1.7n
S_MOS  drain    0    gate 0 SW_IRLZ44N
L_COIL vdd24    mid  {L_COIL}
R_COIL mid      drain {R_COIL_HOT}
D_FLY  drain    vdd24 D_1N5819
C_WALL drain    dish_center 45p
.ends CUBOCT_COIL_CHANNEL

* 3. 12 Pre-compensated Tang Nano 9K FPGA GPIO Outputs (Even vertices 0,2,4,6,8,10 at tick 0+89=89;
*    Odd vertices 1,3,5,7,9,11 at tick 139+89=228 so coil currents intersect at dphi = 139 = A_coh!):
V_FPGA_00 fpga_pin00 0 PULSE(0 3.3 {89  * T_TICK} 3n 3n {T_RING/2} {T_RING})
V_FPGA_01 fpga_pin01 0 PULSE(0 3.3 {228 * T_TICK} 3n 3n {T_RING/2} {T_RING})
V_FPGA_02 fpga_pin02 0 PULSE(0 3.3 {89  * T_TICK} 3n 3n {T_RING/2} {T_RING})
V_FPGA_03 fpga_pin03 0 PULSE(0 3.3 {228 * T_TICK} 3n 3n {T_RING/2} {T_RING})
V_FPGA_04 fpga_pin04 0 PULSE(0 3.3 {89  * T_TICK} 3n 3n {T_RING/2} {T_RING})
V_FPGA_05 fpga_pin05 0 PULSE(0 3.3 {228 * T_TICK} 3n 3n {T_RING/2} {T_RING})
V_FPGA_06 fpga_pin06 0 PULSE(0 3.3 {89  * T_TICK} 3n 3n {T_RING/2} {T_RING})
V_FPGA_07 fpga_pin07 0 PULSE(0 3.3 {228 * T_TICK} 3n 3n {T_RING/2} {T_RING})
V_FPGA_08 fpga_pin08 0 PULSE(0 3.3 {89  * T_TICK} 3n 3n {T_RING/2} {T_RING})
V_FPGA_09 fpga_pin09 0 PULSE(0 3.3 {228 * T_TICK} 3n 3n {T_RING/2} {T_RING})
V_FPGA_10 fpga_pin10 0 PULSE(0 3.3 {89  * T_TICK} 3n 3n {T_RING/2} {T_RING})
V_FPGA_11 fpga_pin11 0 PULSE(0 3.3 {228 * T_TICK} 3n 3n {T_RING/2} {T_RING})

* 4. Instantiate All 12 Cuboctahedron O_2(3) Power Channels around the 90 mm Quartz Petri Dish:
X_CH00 fpga_pin00 drain00 dish_center vdd24 CUBOCT_COIL_CHANNEL
X_CH01 fpga_pin01 drain01 dish_center vdd24 CUBOCT_COIL_CHANNEL
X_CH02 fpga_pin02 drain02 dish_center vdd24 CUBOCT_COIL_CHANNEL
X_CH03 fpga_pin03 drain03 dish_center vdd24 CUBOCT_COIL_CHANNEL
X_CH04 fpga_pin04 drain04 dish_center vdd24 CUBOCT_COIL_CHANNEL
X_CH05 fpga_pin05 drain05 dish_center vdd24 CUBOCT_COIL_CHANNEL
X_CH06 fpga_pin06 drain06 dish_center vdd24 CUBOCT_COIL_CHANNEL
X_CH07 fpga_pin07 drain07 dish_center vdd24 CUBOCT_COIL_CHANNEL
X_CH08 fpga_pin08 drain08 dish_center vdd24 CUBOCT_COIL_CHANNEL
X_CH09 fpga_pin09 drain09 dish_center vdd24 CUBOCT_COIL_CHANNEL
X_CH10 fpga_pin10 drain10 dish_center vdd24 CUBOCT_COIL_CHANNEL
X_CH11 fpga_pin11 drain11 dish_center vdd24 CUBOCT_COIL_CHANNEL

* 5. Petri Dish Interior Air/Electrolyte Cavity Load (R_cavity = 1536 = 3 * 512 Ohm):
R_CAVITY dish_center 0 1536

.model SW_IRLZ44N SW(Ron=0.022 Roff=1Meg Vt=1.8 Vh=0.2)
.model D_1N5819 D(Is=3.16u Rs=0.042 N=1.08 Cjo=110p Vj=0.32 BV=40)

* 6. Automated 12-Channel SPICE Verification Measurements:
.meas TRAN v_vdd24_min MIN V(vdd24) FROM={T_RING} TO={2*T_RING}
.meas TRAN i_total_12coil_peak MAX -I(V_PSU24) FROM={T_RING} TO={2*T_RING}
.meas TRAN v_drain00_max MAX V(drain00) FROM={T_RING} TO={2*T_RING}
.meas TRAN v_drain01_max MAX V(drain01) FROM={T_RING} TO={2*T_RING}
.meas TRAN v_dish_12beam_pp PP V(dish_center) FROM={T_RING} TO={2*T_RING}

.tran 0 {3 * T_RING} 0 {T_TICK / 2}
.end
